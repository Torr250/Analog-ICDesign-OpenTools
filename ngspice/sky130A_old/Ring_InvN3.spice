** sch_path: /foss/designs/sky130A/analog/oscillators/Ring_InvN3.sch
**.subckt Ring_InvN3
XM1 N1 N3 0 0 sky130_fd_pr__nfet_01v8 L=0.15 W=1 nf=1 ad=0.29 as=0.29 pd=2.58 ps=2.58 nrd=0.29 nrs=0.29 sa=0 sb=0 sd=0 mult=1
XM2 N1 N3 VDD VDD sky130_fd_pr__pfet_01v8 L=0.15 W=3 nf=1 ad=0.87 as=0.87 pd=6.58 ps=6.58 nrd=0.0966666666666667
+ nrs=0.0966666666666667 sa=0 sb=0 sd=0 mult=1
XM3 N2 N1 0 0 sky130_fd_pr__nfet_01v8 L=0.15 W=1 nf=1 ad=0.29 as=0.29 pd=2.58 ps=2.58 nrd=0.29 nrs=0.29 sa=0 sb=0 sd=0 mult=1
XM4 N2 N1 VDD VDD sky130_fd_pr__pfet_01v8 L=0.15 W=3 nf=1 ad=0.87 as=0.87 pd=6.58 ps=6.58 nrd=0.0966666666666667
+ nrs=0.0966666666666667 sa=0 sb=0 sd=0 mult=1
XM5 N3 N2 0 0 sky130_fd_pr__nfet_01v8 L=0.15 W=1 nf=1 ad=0.29 as=0.29 pd=2.58 ps=2.58 nrd=0.29 nrs=0.29 sa=0 sb=0 sd=0 mult=1
XM6 N3 N2 VDD VDD sky130_fd_pr__pfet_01v8 L=0.15 W=3 nf=1 ad=0.87 as=0.87 pd=6.58 ps=6.58 nrd=0.0966666666666667
+ nrs=0.0966666666666667 sa=0 sb=0 sd=0 mult=1
V9 net1 0 'VDD'
V7 VDD net1 0
C1 N1 0 25f
C2 VDD N1 25f
C3 N2 0 25f
C4 VDD N2 25f
C5 N3 0 25f
C6 VDD N3 25f
**** begin user architecture code

*.options method=gear
.ic v(n1)=0.2
.param VDD=1.8 TEMP=60
.temp {TEMP}
.csparam vdd1={VDD}
**** interactive sim
.control
  tran 10p 30n uic
  let vlow = {0.1*vdd1}
  let vhigh = {0.9*vdd1}
  let vswitch = {0.5*vdd1}
  meas tran period trig V(n1) val=vswitch td=20n rise=1 targ V(n1) val=vswitch td=20n rise=2
  let freq = 1/period
  print period
  print freq
  option remzerovec
  save all
  write Ring_InvN3.raw
.endc

.lib /libs.tech/combined/sky130.lib.spice tt
**** end user architecture code
**.ends
.GLOBAL VDD
.end
