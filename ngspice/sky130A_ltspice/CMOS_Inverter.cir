CMOS Inverter - sky130A (traducido de CMOS_Inverter.asc)
.param Freq=1G

.include "sky130A_ltspice_tt.lib"

* Alimentacion
VDD VDD 0 1.8
* Entrada: PULSE(V1 V2 TD TR TF PW PER)
VIN IN 0 PULSE(0 1.8 {1/Freq} 30p 30p {0.5/Freq} {1/Freq})

* Inversor: PMOS (U2) w=2u, NMOS (U1) w=1u, l=0.15u en ambos
XPMOS OUT IN VDD VDD xpfet_01v8 w=2u l=0.15u
XNMOS OUT IN 0 0 xnfet_01v8 w=1u l=0.15u

.tran 1p 10n 0 1p

.meas tran tpHL TRIG V(IN) VAL=0.9 RISE=3 TARG V(OUT) VAL=0.9 FALL=3
.meas tran tpLH TRIG V(IN) VAL=0.9 FALL=3 TARG V(OUT) VAL=0.9 RISE=3

.control
run
write CMOS_Inverter.raw
.endc

.end
