CMOS Inverter - sky130A (traducido de CMOS_Inverter.asc)
.param Freq=1G

.lib /libs.tech/combined/sky130.lib.spice tt

* Alimentacion
VDD VDD 0 1.8
* Entrada: PULSE(V1 V2 TD TR TF PW PER)
VIN IN 0 PULSE(0 1.8 {1/Freq} 30p 30p {0.5/Freq} {1/Freq})

* Inversor: PMOS (U2) w=2u, NMOS (U1) w=1u, l=0.15u en ambos
XM1 OUT IN 0 0 sky130_fd_pr__nfet_01v8 L=0.15 W=1 nf=1 ad=0.29 as=0.29 pd=2.58 ps=2.58 nrd=0.29 nrs=0.29 sa=0 sb=0 sd=0 mult=1
XM2 OUT IN VDD VDD sky130_fd_pr__pfet_01v8 L=0.15 W=2 nf=1 ad=0.58 as=0.58 pd=4.58 ps=4.58 nrd=0.145 nrs=0.145 sa=0 sb=0 sd=0 mult=1

.tran 1p 10n 0 1p

.meas tran tpHL TRIG V(IN) VAL=0.9 RISE=3 TARG V(OUT) VAL=0.9 FALL=3
.meas tran tpLH TRIG V(IN) VAL=0.9 FALL=3 TARG V(OUT) VAL=0.9 RISE=3

.control
run
write CMOS_Inverter.raw
.endc

.end
