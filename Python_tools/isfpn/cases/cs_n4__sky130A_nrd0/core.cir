** sch_path: /foss/designs/sky130A/analog/oscillators/CS_Pseudo_diff_N4.sch
* CS_Pseudo_diff_N4 core (no .lib/.control)
XM1 N1 N4 0 0 sky130_fd_pr__nfet_01v8 L=0.15 W=1 nf=1 ad=0.265 as=0.265 pd=2.53 ps=2.53   nrd=0 nrs=0 sa=0 sb=0 sd=0 mult=1
XM2 N1 N4 VCS VCS sky130_fd_pr__pfet_01v8 L=0.15 W=3 nf=1 ad=0.795 as=0.795 pd=6.53 ps=6.53  nrd=0 nrs=0 sa=0 sb=0 sd=0 mult=1
XM3 N2 N1 0 0 sky130_fd_pr__nfet_01v8 L=0.15 W=1 nf=1 ad=0.265 as=0.265 pd=2.53 ps=2.53   nrd=0 nrs=0 sa=0 sb=0 sd=0 mult=1
XM4 N2 N1 VCS VCS sky130_fd_pr__pfet_01v8 L=0.15 W=3 nf=1 ad=0.795 as=0.795 pd=6.53 ps=6.53  nrd=0 nrs=0 sa=0 sb=0 sd=0 mult=1
V9 net1 0 'VDD'
V7 VDD net1 0
C1 N1 0 25f
C2 VCS N1 25f
C5 N4 0 25f
C6 VCS N4 25f
XM5 N3 N2 0 0 sky130_fd_pr__nfet_01v8 L=0.15 W=1 nf=1 ad=0.265 as=0.265 pd=2.53 ps=2.53   nrd=0 nrs=0 sa=0 sb=0 sd=0 mult=1
XM6 N3 N2 VCS VCS sky130_fd_pr__pfet_01v8 L=0.15 W=3 nf=1 ad=0.795 as=0.795 pd=6.53 ps=6.53  nrd=0 nrs=0 sa=0 sb=0 sd=0 mult=1
XM7 N4 N3 0 0 sky130_fd_pr__nfet_01v8 L=0.15 W=1 nf=1 ad=0.265 as=0.265 pd=2.53 ps=2.53   nrd=0 nrs=0 sa=0 sb=0 sd=0 mult=1
XM8 N4 N3 VCS VCS sky130_fd_pr__pfet_01v8 L=0.15 W=3 nf=1 ad=0.795 as=0.795 pd=6.53 ps=6.53  nrd=0 nrs=0 sa=0 sb=0 sd=0 mult=1
C3 N3 0 25f
C4 VCS N3 25f
C7 N2 0 25f
C8 VCS N2 25f
XM9 N3 N1 0 0 sky130_fd_pr__nfet_01v8 L=0.15 W=1 nf=1 ad=0.265 as=0.265 pd=2.53 ps=2.53   nrd=0 nrs=0 sa=0 sb=0 sd=0 mult=1
XM10 N3 N1 VCS VCS sky130_fd_pr__pfet_01v8 L=0.15 W=3 nf=1 ad=0.795 as=0.795 pd=6.53 ps=6.53  nrd=0 nrs=0 sa=0 sb=0 sd=0 mult=1
XM11 N1 N3 0 0 sky130_fd_pr__nfet_01v8 L=0.15 W=1 nf=1 ad=0.265 as=0.265 pd=2.53 ps=2.53   nrd=0 nrs=0 sa=0 sb=0 sd=0 mult=1
XM12 N1 N3 VCS VCS sky130_fd_pr__pfet_01v8 L=0.15 W=3 nf=1 ad=0.795 as=0.795 pd=6.53 ps=6.53  nrd=0 nrs=0 sa=0 sb=0 sd=0 mult=1
XM13 N4 N2 0 0 sky130_fd_pr__nfet_01v8 L=0.15 W=1 nf=1 ad=0.265 as=0.265 pd=2.53 ps=2.53   nrd=0 nrs=0 sa=0 sb=0 sd=0 mult=1
XM14 N4 N2 VCS VCS sky130_fd_pr__pfet_01v8 L=0.15 W=3 nf=1 ad=0.795 as=0.795 pd=6.53 ps=6.53  nrd=0 nrs=0 sa=0 sb=0 sd=0 mult=1
XM15 N2 N4 0 0 sky130_fd_pr__nfet_01v8 L=0.15 W=1 nf=1 ad=0.265 as=0.265 pd=2.53 ps=2.53   nrd=0 nrs=0 sa=0 sb=0 sd=0 mult=1
XM16 N2 N4 VCS VCS sky130_fd_pr__pfet_01v8 L=0.15 W=3 nf=1 ad=0.795 as=0.795 pd=6.53 ps=6.53  nrd=0 nrs=0 sa=0 sb=0 sd=0 mult=1
XM17 net2 VBP VDD VDD sky130_fd_pr__pfet_01v8 L=0.3 W=6 nf=1 ad=1.59 as=1.59 pd=12.53 ps=12.53  nrd=0 nrs=0 sa=0 sb=0 sd=0 mult=40 m=40
XM18 VBP VBP VDD VDD sky130_fd_pr__pfet_01v8 L=0.3 W=6 nf=1 ad=1.59 as=1.59 pd=12.53 ps=12.53  nrd=0 nrs=0 sa=0 sb=0 sd=0 mult=40 m=40
I0 VBP 0 500u
V1 net2 VCS 0
E1 N13 0 N1 N3 1
E2 N24 0 N2 N4 1
