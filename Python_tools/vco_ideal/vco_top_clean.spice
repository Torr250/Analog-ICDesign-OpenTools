* Netlist 1: simulates the vco_ideal subcircuit (noiseless)
.include vco_ideal_lib.spice
Vctrl vctrl 0 1.65
Xvco vctrl out vco_ideal vdd=3.3 f0=500meg kvco=80meg vc0=1.65
.control
  tran 10p 100n uic
  option remzerovec
  save all
  write vco_top_clean.raw
.endc
.end
