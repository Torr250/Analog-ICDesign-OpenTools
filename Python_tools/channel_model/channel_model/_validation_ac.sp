* internal validation (ideal source directly into the filter)
* ============================================================
* Channel model: LOSS ONLY (shelving filter, 1 stage(s) in
* cascade), no transmission lines or reflection
* generated by channel_model_generator.py
*
* Fitted loss: 0.000 dB at DC, 6.000 dB @ 1.0000 GHz, 10.000 dB @ 8.0000 GHz
* fp1=0.453618 GHz   fp2=1.455681 GHz   (per stage, x1 stages)
*
* Usage: X1 input_node output_node CHANNEL_MODEL
* The input has infinite impedance (senses, does not load) and the
* output is an ideal source (zero output impedance) -- it does not
* represent Z0 or reflections, only the magnitude loss shape.
* ============================================================
.subckt CHANNEL_MODEL in out
Ebuf_in1 mid_in1 0 in 0 1
R1 mid_in1 mid_r1 3.508569e+02
C1 mid_r1 0 1.000000e-12
Bshelf1 shelf_out1 0 V = V(mid_r1) + (V(mid_in1)-V(mid_r1))*0.311618952
Epad out 0 shelf_out1 0 1.000000000
.ends
Vin in_src 0 AC 1
X1 in_src out CHANNEL_MODEL
.control
  ac dec 50 1e6 16000000000.0
  let loss_db = 20*log10(abs(v(out)))
  meas ac loss_dc FIND loss_db AT=1e6
  meas ac loss1 FIND loss_db AT=1000000000.0
  meas ac loss2 FIND loss_db AT=8000000000.0
  print loss_dc
  print loss1
  print loss2
.endc
.end
