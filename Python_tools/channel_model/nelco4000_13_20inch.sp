* ============================================================
* Channel model: LOSS ONLY (shelving filter, 3 stage(s) in
* cascade), no transmission lines or reflection
* generated by channel_model_generator.py
*
* Fitted loss: 0.000 dB at DC, 15.000 dB @ 4.0000 GHz, 26.000 dB @ 8.0000 GHz
* fp1=2.483354 GHz   fp2=10.820298 GHz   (per stage, x3 stages)
*
* Usage: X1 input_node output_node CHANNEL_MODEL
* The input has infinite impedance (senses, does not load) and the
* output is an ideal source (zero output impedance) -- it does not
* represent Z0 or reflections, only the magnitude loss shape.
* ============================================================
.subckt nelco4000_13_20inch in out
Ebuf_in1 mid_in1 0 in 0 1
R1 mid_in1 mid_r1 6.408871e+01
C1 mid_r1 0 1.000000e-12
Bshelf1 shelf_out1 0 V = V(mid_r1) + (V(mid_in1)-V(mid_r1))*0.229508835
Ebuf_in2 mid_in2 0 shelf_out1 0 1
R2 mid_in2 mid_r2 6.408871e+01
C2 mid_r2 0 1.000000e-12
Bshelf2 shelf_out2 0 V = V(mid_r2) + (V(mid_in2)-V(mid_r2))*0.229508835
Ebuf_in3 mid_in3 0 shelf_out2 0 1
R3 mid_in3 mid_r3 6.408871e+01
C3 mid_r3 0 1.000000e-12
Bshelf3 shelf_out3 0 V = V(mid_r3) + (V(mid_in3)-V(mid_r3))*0.229508835
Epad out 0 shelf_out3 0 1.000000000
.ends
