** sch_path: /foss/designs/atorralba/cyc/gf180mcuD/analog/VCO/Ring_InvN3.sch
**.subckt Ring_InvN3
V9 net1 0 'VDD'
V7 VDD net1 0
C1 N1 0 25f
C2 VDD N1 25f
C3 N2 0 25f
C4 VDD N2 25f
C5 N3 0 25f
C6 VDD N3 25f
XM1 N1 N3 VDD VDD pfet_03v3 L=0.28u W=3u nf=1 ad='int((nf+1)/2) * W/nf * 0.18u' as='int((nf+2)/2) * W/nf * 0.18u' pd='2*int((nf+1)/2) * (W/nf + 0.18u)'
+ ps='2*int((nf+2)/2) * (W/nf + 0.18u)' nrd='0.18u / W' nrs='0.18u / W' sa=0 sb=0 sd=0
XM2 N1 N3 0 0 nfet_03v3 L=0.28u W=1u nf=1 ad='int((nf+1)/2) * W/nf * 0.18u' as='int((nf+2)/2) * W/nf * 0.18u' pd='2*int((nf+1)/2) * (W/nf + 0.18u)'
+ ps='2*int((nf+2)/2) * (W/nf + 0.18u)' nrd='0.18u / W' nrs='0.18u / W' sa=0 sb=0 sd=0
XM3 N2 N1 VDD VDD pfet_03v3 L=0.28u W=3u nf=1 ad='int((nf+1)/2) * W/nf * 0.18u' as='int((nf+2)/2) * W/nf * 0.18u' pd='2*int((nf+1)/2) * (W/nf + 0.18u)'
+ ps='2*int((nf+2)/2) * (W/nf + 0.18u)' nrd='0.18u / W' nrs='0.18u / W' sa=0 sb=0 sd=0
XM4 N2 N1 0 0 nfet_03v3 L=0.28u W=1u nf=1 ad='int((nf+1)/2) * W/nf * 0.18u' as='int((nf+2)/2) * W/nf * 0.18u' pd='2*int((nf+1)/2) * (W/nf + 0.18u)'
+ ps='2*int((nf+2)/2) * (W/nf + 0.18u)' nrd='0.18u / W' nrs='0.18u / W' sa=0 sb=0 sd=0
XM5 N3 N2 VDD VDD pfet_03v3 L=0.28u W=3u nf=1 ad='int((nf+1)/2) * W/nf * 0.18u' as='int((nf+2)/2) * W/nf * 0.18u' pd='2*int((nf+1)/2) * (W/nf + 0.18u)'
+ ps='2*int((nf+2)/2) * (W/nf + 0.18u)' nrd='0.18u / W' nrs='0.18u / W' sa=0 sb=0 sd=0
XM6 N3 N2 0 0 nfet_03v3 L=0.28u W=1u nf=1 ad='int((nf+1)/2) * W/nf * 0.18u' as='int((nf+2)/2) * W/nf * 0.18u' pd='2*int((nf+1)/2) * (W/nf + 0.18u)'
+ ps='2*int((nf+2)/2) * (W/nf + 0.18u)' nrd='0.18u / W' nrs='0.18u / W' sa=0 sb=0 sd=0
**** begin user architecture code

*.options method=gear
.include /foss/designs/atorralba/repo/Analog-ICDesign-OpenTools/ngspice/gf180mcuD/design.ngspice
.lib /foss/designs/atorralba/repo/Analog-ICDesign-OpenTools/ngspice/gf180mcuD/sm141064.ngspice typical
.ic v(n1)=0.2
.param VDD=3.3 TEMP=60
.temp {TEMP}
.csparam vdd1={VDD}
**** interactive sim
.control
  tran 10p 30n uic
  let vlow = {0.1*vdd1}
  let vhigh = {0.9*vdd1}
  let vswitch = {0.5*vdd1}
  meas tran period trig V(n1) val=vswitch td=20n rise=1 targ V(n1) val=vswitch td=20n rise=2
  let freq = 1/period
  print period
  print freq
  option remzerovec
  save all
  write Ring_InvN3.raw
.endc

*.include /foss/pdks/gf180mcuD/libs.tech/ngspice/design.ngspice
*.lib /foss/pdks/gf180mcuD/libs.tech/ngspice/sm141064.ngspice typical

**** end user architecture code
**.ends
.GLOBAL VDD
.end
