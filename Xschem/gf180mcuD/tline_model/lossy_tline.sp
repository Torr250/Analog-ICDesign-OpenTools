* Modelo de linea de transmision con perdida, generado por tline_model.py
* Especificacion: Z0=50.0000 Ohm, TD=1.0000 ns, perdida=8.00 dB @ 1.000 GHz
* Totales:  R=92.102233 Ohm  L=50.000000 nH  G=0.000000 uS  C=20.000000 pF
* 100 secciones (topologia Pi): R_seg=0.921022 Ohm  L_seg=500.0000 pH  G_seg=0.0000 nS  C_seg=200.0000 fF
.subckt LOSSY_TLINE in out
Cend_in in 0 1.000000e-13
R1 in m1 9.210223e-01
L1 m1 n1 5.000000e-10
C1 n1 0 2.000000e-13
R2 n1 m2 9.210223e-01
L2 m2 n2 5.000000e-10
C2 n2 0 2.000000e-13
R3 n2 m3 9.210223e-01
L3 m3 n3 5.000000e-10
C3 n3 0 2.000000e-13
R4 n3 m4 9.210223e-01
L4 m4 n4 5.000000e-10
C4 n4 0 2.000000e-13
R5 n4 m5 9.210223e-01
L5 m5 n5 5.000000e-10
C5 n5 0 2.000000e-13
R6 n5 m6 9.210223e-01
L6 m6 n6 5.000000e-10
C6 n6 0 2.000000e-13
R7 n6 m7 9.210223e-01
L7 m7 n7 5.000000e-10
C7 n7 0 2.000000e-13
R8 n7 m8 9.210223e-01
L8 m8 n8 5.000000e-10
C8 n8 0 2.000000e-13
R9 n8 m9 9.210223e-01
L9 m9 n9 5.000000e-10
C9 n9 0 2.000000e-13
R10 n9 m10 9.210223e-01
L10 m10 n10 5.000000e-10
C10 n10 0 2.000000e-13
R11 n10 m11 9.210223e-01
L11 m11 n11 5.000000e-10
C11 n11 0 2.000000e-13
R12 n11 m12 9.210223e-01
L12 m12 n12 5.000000e-10
C12 n12 0 2.000000e-13
R13 n12 m13 9.210223e-01
L13 m13 n13 5.000000e-10
C13 n13 0 2.000000e-13
R14 n13 m14 9.210223e-01
L14 m14 n14 5.000000e-10
C14 n14 0 2.000000e-13
R15 n14 m15 9.210223e-01
L15 m15 n15 5.000000e-10
C15 n15 0 2.000000e-13
R16 n15 m16 9.210223e-01
L16 m16 n16 5.000000e-10
C16 n16 0 2.000000e-13
R17 n16 m17 9.210223e-01
L17 m17 n17 5.000000e-10
C17 n17 0 2.000000e-13
R18 n17 m18 9.210223e-01
L18 m18 n18 5.000000e-10
C18 n18 0 2.000000e-13
R19 n18 m19 9.210223e-01
L19 m19 n19 5.000000e-10
C19 n19 0 2.000000e-13
R20 n19 m20 9.210223e-01
L20 m20 n20 5.000000e-10
C20 n20 0 2.000000e-13
R21 n20 m21 9.210223e-01
L21 m21 n21 5.000000e-10
C21 n21 0 2.000000e-13
R22 n21 m22 9.210223e-01
L22 m22 n22 5.000000e-10
C22 n22 0 2.000000e-13
R23 n22 m23 9.210223e-01
L23 m23 n23 5.000000e-10
C23 n23 0 2.000000e-13
R24 n23 m24 9.210223e-01
L24 m24 n24 5.000000e-10
C24 n24 0 2.000000e-13
R25 n24 m25 9.210223e-01
L25 m25 n25 5.000000e-10
C25 n25 0 2.000000e-13
R26 n25 m26 9.210223e-01
L26 m26 n26 5.000000e-10
C26 n26 0 2.000000e-13
R27 n26 m27 9.210223e-01
L27 m27 n27 5.000000e-10
C27 n27 0 2.000000e-13
R28 n27 m28 9.210223e-01
L28 m28 n28 5.000000e-10
C28 n28 0 2.000000e-13
R29 n28 m29 9.210223e-01
L29 m29 n29 5.000000e-10
C29 n29 0 2.000000e-13
R30 n29 m30 9.210223e-01
L30 m30 n30 5.000000e-10
C30 n30 0 2.000000e-13
R31 n30 m31 9.210223e-01
L31 m31 n31 5.000000e-10
C31 n31 0 2.000000e-13
R32 n31 m32 9.210223e-01
L32 m32 n32 5.000000e-10
C32 n32 0 2.000000e-13
R33 n32 m33 9.210223e-01
L33 m33 n33 5.000000e-10
C33 n33 0 2.000000e-13
R34 n33 m34 9.210223e-01
L34 m34 n34 5.000000e-10
C34 n34 0 2.000000e-13
R35 n34 m35 9.210223e-01
L35 m35 n35 5.000000e-10
C35 n35 0 2.000000e-13
R36 n35 m36 9.210223e-01
L36 m36 n36 5.000000e-10
C36 n36 0 2.000000e-13
R37 n36 m37 9.210223e-01
L37 m37 n37 5.000000e-10
C37 n37 0 2.000000e-13
R38 n37 m38 9.210223e-01
L38 m38 n38 5.000000e-10
C38 n38 0 2.000000e-13
R39 n38 m39 9.210223e-01
L39 m39 n39 5.000000e-10
C39 n39 0 2.000000e-13
R40 n39 m40 9.210223e-01
L40 m40 n40 5.000000e-10
C40 n40 0 2.000000e-13
R41 n40 m41 9.210223e-01
L41 m41 n41 5.000000e-10
C41 n41 0 2.000000e-13
R42 n41 m42 9.210223e-01
L42 m42 n42 5.000000e-10
C42 n42 0 2.000000e-13
R43 n42 m43 9.210223e-01
L43 m43 n43 5.000000e-10
C43 n43 0 2.000000e-13
R44 n43 m44 9.210223e-01
L44 m44 n44 5.000000e-10
C44 n44 0 2.000000e-13
R45 n44 m45 9.210223e-01
L45 m45 n45 5.000000e-10
C45 n45 0 2.000000e-13
R46 n45 m46 9.210223e-01
L46 m46 n46 5.000000e-10
C46 n46 0 2.000000e-13
R47 n46 m47 9.210223e-01
L47 m47 n47 5.000000e-10
C47 n47 0 2.000000e-13
R48 n47 m48 9.210223e-01
L48 m48 n48 5.000000e-10
C48 n48 0 2.000000e-13
R49 n48 m49 9.210223e-01
L49 m49 n49 5.000000e-10
C49 n49 0 2.000000e-13
R50 n49 m50 9.210223e-01
L50 m50 n50 5.000000e-10
C50 n50 0 2.000000e-13
R51 n50 m51 9.210223e-01
L51 m51 n51 5.000000e-10
C51 n51 0 2.000000e-13
R52 n51 m52 9.210223e-01
L52 m52 n52 5.000000e-10
C52 n52 0 2.000000e-13
R53 n52 m53 9.210223e-01
L53 m53 n53 5.000000e-10
C53 n53 0 2.000000e-13
R54 n53 m54 9.210223e-01
L54 m54 n54 5.000000e-10
C54 n54 0 2.000000e-13
R55 n54 m55 9.210223e-01
L55 m55 n55 5.000000e-10
C55 n55 0 2.000000e-13
R56 n55 m56 9.210223e-01
L56 m56 n56 5.000000e-10
C56 n56 0 2.000000e-13
R57 n56 m57 9.210223e-01
L57 m57 n57 5.000000e-10
C57 n57 0 2.000000e-13
R58 n57 m58 9.210223e-01
L58 m58 n58 5.000000e-10
C58 n58 0 2.000000e-13
R59 n58 m59 9.210223e-01
L59 m59 n59 5.000000e-10
C59 n59 0 2.000000e-13
R60 n59 m60 9.210223e-01
L60 m60 n60 5.000000e-10
C60 n60 0 2.000000e-13
R61 n60 m61 9.210223e-01
L61 m61 n61 5.000000e-10
C61 n61 0 2.000000e-13
R62 n61 m62 9.210223e-01
L62 m62 n62 5.000000e-10
C62 n62 0 2.000000e-13
R63 n62 m63 9.210223e-01
L63 m63 n63 5.000000e-10
C63 n63 0 2.000000e-13
R64 n63 m64 9.210223e-01
L64 m64 n64 5.000000e-10
C64 n64 0 2.000000e-13
R65 n64 m65 9.210223e-01
L65 m65 n65 5.000000e-10
C65 n65 0 2.000000e-13
R66 n65 m66 9.210223e-01
L66 m66 n66 5.000000e-10
C66 n66 0 2.000000e-13
R67 n66 m67 9.210223e-01
L67 m67 n67 5.000000e-10
C67 n67 0 2.000000e-13
R68 n67 m68 9.210223e-01
L68 m68 n68 5.000000e-10
C68 n68 0 2.000000e-13
R69 n68 m69 9.210223e-01
L69 m69 n69 5.000000e-10
C69 n69 0 2.000000e-13
R70 n69 m70 9.210223e-01
L70 m70 n70 5.000000e-10
C70 n70 0 2.000000e-13
R71 n70 m71 9.210223e-01
L71 m71 n71 5.000000e-10
C71 n71 0 2.000000e-13
R72 n71 m72 9.210223e-01
L72 m72 n72 5.000000e-10
C72 n72 0 2.000000e-13
R73 n72 m73 9.210223e-01
L73 m73 n73 5.000000e-10
C73 n73 0 2.000000e-13
R74 n73 m74 9.210223e-01
L74 m74 n74 5.000000e-10
C74 n74 0 2.000000e-13
R75 n74 m75 9.210223e-01
L75 m75 n75 5.000000e-10
C75 n75 0 2.000000e-13
R76 n75 m76 9.210223e-01
L76 m76 n76 5.000000e-10
C76 n76 0 2.000000e-13
R77 n76 m77 9.210223e-01
L77 m77 n77 5.000000e-10
C77 n77 0 2.000000e-13
R78 n77 m78 9.210223e-01
L78 m78 n78 5.000000e-10
C78 n78 0 2.000000e-13
R79 n78 m79 9.210223e-01
L79 m79 n79 5.000000e-10
C79 n79 0 2.000000e-13
R80 n79 m80 9.210223e-01
L80 m80 n80 5.000000e-10
C80 n80 0 2.000000e-13
R81 n80 m81 9.210223e-01
L81 m81 n81 5.000000e-10
C81 n81 0 2.000000e-13
R82 n81 m82 9.210223e-01
L82 m82 n82 5.000000e-10
C82 n82 0 2.000000e-13
R83 n82 m83 9.210223e-01
L83 m83 n83 5.000000e-10
C83 n83 0 2.000000e-13
R84 n83 m84 9.210223e-01
L84 m84 n84 5.000000e-10
C84 n84 0 2.000000e-13
R85 n84 m85 9.210223e-01
L85 m85 n85 5.000000e-10
C85 n85 0 2.000000e-13
R86 n85 m86 9.210223e-01
L86 m86 n86 5.000000e-10
C86 n86 0 2.000000e-13
R87 n86 m87 9.210223e-01
L87 m87 n87 5.000000e-10
C87 n87 0 2.000000e-13
R88 n87 m88 9.210223e-01
L88 m88 n88 5.000000e-10
C88 n88 0 2.000000e-13
R89 n88 m89 9.210223e-01
L89 m89 n89 5.000000e-10
C89 n89 0 2.000000e-13
R90 n89 m90 9.210223e-01
L90 m90 n90 5.000000e-10
C90 n90 0 2.000000e-13
R91 n90 m91 9.210223e-01
L91 m91 n91 5.000000e-10
C91 n91 0 2.000000e-13
R92 n91 m92 9.210223e-01
L92 m92 n92 5.000000e-10
C92 n92 0 2.000000e-13
R93 n92 m93 9.210223e-01
L93 m93 n93 5.000000e-10
C93 n93 0 2.000000e-13
R94 n93 m94 9.210223e-01
L94 m94 n94 5.000000e-10
C94 n94 0 2.000000e-13
R95 n94 m95 9.210223e-01
L95 m95 n95 5.000000e-10
C95 n95 0 2.000000e-13
R96 n95 m96 9.210223e-01
L96 m96 n96 5.000000e-10
C96 n96 0 2.000000e-13
R97 n96 m97 9.210223e-01
L97 m97 n97 5.000000e-10
C97 n97 0 2.000000e-13
R98 n97 m98 9.210223e-01
L98 m98 n98 5.000000e-10
C98 n98 0 2.000000e-13
R99 n98 m99 9.210223e-01
L99 m99 n99 5.000000e-10
C99 n99 0 2.000000e-13
R100 n99 m100 9.210223e-01
L100 m100 out 5.000000e-10
C100 out 0 1.000000e-13
.ends
